`include "constants.vams"
`include "disciplines.vams"

module cg_batch_l0_cross_event_latch_parameter_diversity_0001(vp, vn, vflag);
  input vp;
  input vn;
  output vflag;
  electrical vp, vn, vflag;
  parameter real vth = 0.0;
  parameter real vhigh = 1.2;
  parameter real vlow = 0.0;
  parameter real tdetect = 2e-10;
  integer latched;
  real diff_v;

  analog begin
    @(initial_step) latched = 0;
    diff_v = V(vp) - V(vn);
    @(cross(diff_v - vth, +1)) latched = 1;
    if (latched != 0) begin
      V(vflag) <+ transition(vhigh, tdetect, tdetect);
    end else begin
      V(vflag) <+ transition(vlow, tdetect, tdetect);
    end
  end
endmodule
