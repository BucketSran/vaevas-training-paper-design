// Auto-generated shallow EVAS Rust smoke harness for cand_cg_batch_l1_gain_probe_tb_parameter_diversity_0001
simulator lang=spectre
global 0

ahdl_include "solution.va"

// no input voltage source inferred; instantiate for parser smoke only

IDUT (vin vout) cg_batch_l1_gain_probe_tb_parameter_diversity_0001

tran tran stop=100n maxstep=100p
save vin:3f vout:3f
