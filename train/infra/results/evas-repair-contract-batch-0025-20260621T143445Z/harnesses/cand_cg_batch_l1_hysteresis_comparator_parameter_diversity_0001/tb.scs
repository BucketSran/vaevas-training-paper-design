// Auto-generated shallow EVAS Rust smoke harness for cand_cg_batch_l1_hysteresis_comparator_parameter_diversity_0001
simulator lang=spectre
global 0

ahdl_include "solution.va"

V_vip (vip 0) vsource type=pwl wave=[0 0.40 20n 0.60 100n 0.60]
V_vim (vim 0) vsource dc=0.45 type=dc

IDUT (vip vim vout) cg_batch_l1_hysteresis_comparator_parameter_diversity_0001

tran tran stop=100n maxstep=100p
save vip:3f vim:3f vout:3f
