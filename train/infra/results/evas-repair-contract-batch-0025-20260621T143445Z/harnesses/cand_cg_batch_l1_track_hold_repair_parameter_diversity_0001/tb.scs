// Auto-generated shallow EVAS Rust smoke harness for cand_cg_batch_l1_track_hold_repair_parameter_diversity_0001
simulator lang=spectre
global 0

ahdl_include "solution.va"

V_vin (vin 0) vsource dc=0.45 type=dc
V_vclk (vclk 0) vsource type=pulse val0=0 val1=1.0 period=10n delay=1n rise=100p fall=100p width=4.8n

IDUT (vin vclk vhold) cg_batch_l1_track_hold_repair_parameter_diversity_0001

tran tran stop=100n maxstep=100p
save vin:3f vclk:d vhold:d
